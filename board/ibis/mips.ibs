[IBIS Ver]   4.2
[File Name]  mips.ibs
[File Rev]   3.0
[Date]   January 15, 2024
[Source]   Altera Corporation
[Notes]   - The models are designated as "Final" and have been correlated against physical device operation.
   - This IBIS model is checked using IBISCHK v5.0.4
   There are no known errors and warnings reported.
   - There are no known limitations for this IBIS model release.
   - Contact point: Altera Corporation, http://www.altera.com/corporate/contact/con-index.html
   - This file is generated using Quartus II Version 23.1std.0 Build 991 11/28/2023 SC Lite Edition
   - Unused IOs which have been assigned as tri-stated inputs or as outputs driving any signal in Quartus II
   arerepresented by the NC.
   - Only general purpose IBIS models are supported.
   Revision History
   - v1.0
   - Initial release of MAX 10 IBIS models. Models are based on pre-layout and early engineering info.
   - v2.0
   - Models are based on post-layout, may be missing certain features.
   - v3.0
   - Models have undergone final correlation against physical device operation.
[Disclaimer] Data is for modeling purposes only and is not guaranteed.
[Copyright]  Copyright (C) 2023  Intel Corporation. All rights reserved.
[Component]  10M50DAF484C7G_mips
[Manufacturer] Altera Corporation
[Package]
| RLC values are for 484 FBGA package
| variable  typ   min   max
R_pkg   551m   176m   874m
L_pkg   5.02nH   1.81nH   8.14nH
C_pkg   1.08pF   0.55pF   1.67pF
[Pin] signal_name   model_name   R_pin   L_pin   C_pin
A1   GND   GND
A10   LEDR[2]   lvttl_cio_d8s2   618.8m   5.890nH   1.083pF
A11   LEDR[8]   lvttl_cio_d8s2   572.3m   5.833nH   1.012pF
A12   SW[4]   lvttl_cin_p   548.0m   5.374nH   0.985pF
A13   SW[6]   lvttl_cin_p   565.0m   4.694nH   0.976pF
A14   SW[7]   lvttl_cin_p   539.8m   5.464nH   0.955pF
A16   HEX1[7]   lvttl_cio_d8s2   551.5m   4.756nH   1.106pF
A17   HEX1[4]   lvttl_cio_d8s2   622.8m   5.389nH   1.286pF
A18   HEX1[5]   lvttl_cio_d8s2   646.5m   5.203nH   1.362pF
A19   HEX2[7]   lvttl_cio_d8s2   797.4m   6.594nH   1.419pF
A20   HEX2[1]   lvttl_cio_d8s2   806.9m   7.451nH   1.498pF
A21   HEX2[3]   lvttl_rio_d8s2   852.2m   7.511nH   1.592pF
A22   GND   GND
A7   KEY[1]   33schmitttrig_cin_p   794.5m   7.027nH   1.446pF
A8   LEDR[0]   lvttl_cio_d8s2   739.8m   7.540nH   1.314pF
A9   LEDR[1]   lvttl_cio_d8s2   635.8m   6.193nH   1.167pF
AA1   VGA_R[0]   lvttl_cio_d8s2   831.5m   8.088nH   1.631pF
AA11  ARDUINO_IO[6]   lvttl_cio_d8s2_p   454.1m   4.243nH   0.978pF
AA12  ARDUINO_IO[7]   lvttl_cio_d8s2_p   439.1m   4.075nH   0.927pF
AA17  ARDUINO_IO[9]   lvttl_cio_d8s2_p   556.4m   4.977nH   1.176pF
AA18  GND   GND
AA19  ARDUINO_IO[11]   lvttl_cio_d8s2_p   673.6m   6.235nH   1.426pF
AA20  ARDUINO_IO[15]   lvttl_cio_d8s2_p   840.9m   6.919nH   1.549pF
AA21  DRAM_DQ[3]   lvttl_rio_d8s2_p   715.6m   6.248nH   1.418pF
AA22  DRAM_DQ[2]   lvttl_rio_d8s2_p   740.2m   6.080nH   1.505pF
AA4   GND   GND
AB1   GND   GND
AB15  GSENSOR_SCLK   lvttl_cio_d8s2   632.3m   5.464nH   1.127pF
AB16  GSENSOR_CS_N   lvttl_cio_d8s2   599.0m   5.784nH   1.075pF
AB17  ARDUINO_IO[8]   lvttl_cio_d8s2_p   681.1m   5.577nH   1.408pF
AB19  ARDUINO_IO[10]   lvttl_cio_d8s2_p   813.9m   7.625nH   1.501pF
AB20  ARDUINO_IO[13]   lvttl_cio_d8s2_p   861.3m   7.066nH   1.555pF
AB21  ARDUINO_IO[14]   lvttl_cio_d8s2_p   851.2m   7.339nH   1.621pF
AB22  GND   GND
AB5   ARDUINO_IO[0]   lvttl_cio_d8s2_p   705.9m   6.877nH   1.304pF
AB6   ARDUINO_IO[1]   lvttl_cio_d8s2_p   667.4m   6.499nH   1.395pF
AB7   ARDUINO_IO[2]   lvttl_cio_d8s2_p   615.8m   5.871nH   1.273pF
AB8   ARDUINO_IO[3]   lvttl_cio_d8s2_p   649.1m   6.831nH   1.219pF
AB9   ARDUINO_IO[4]   lvttl_cio_d8s2_p   539.0m   5.869nH   0.952pF
B10   LEDR[3]   lvttl_cio_d8s2   432.0m   3.866nH   0.928pF
B11   LEDR[9]   lvttl_cio_d8s2   432.2m   4.170nH   0.927pF
B12   SW[5]   lvttl_cin_p   428.1m   3.777nH   0.874pF
B13   GND   GND
B14   SW[8]   lvttl_cin_p   531.5m   4.798nH   0.935pF
B16   HEX1[3]   lvttl_cio_d8s2   548.2m   4.460nH   1.125pF
B17   HEX1[6]   lvttl_cio_d8s2   583.7m   4.729nH   1.194pF
B18   GND   GND
B19   HEX2[2]   lvttl_cio_d8s2   750.6m   6.930nH   1.380pF
B20   HEX2[0]   lvttl_rio_d8s2   784.2m   7.629nH   1.484pF
B21   HEX2[4]   lvttl_rio_d8s2   810.9m   7.496nH   1.501pF
B22   HEX2[6]   lvttl_rio_d8s2   874.6m   7.174nH   1.590pF
B6   GND   GND
B8   KEY[0]   33schmitttrig_cin_p   653.9m   5.581nH   1.235pF
B9   GND   GND
C10   SW[0]   lvttl_cin_p   360.7m   3.168nH   0.905pF
C11   SW[1]   lvttl_cin_p   356.1m   3.552nH   0.891pF
C12   SW[3]   lvttl_cin_p   372.1m   3.451nH   0.787pF
C13   LEDR[5]   lvttl_cio_d8s2   376.7m   3.306nH   0.800pF
C14   HEX0[0]   lvttl_cio_d8s2   374.1m   3.688nH   0.772pF
C15   HEX0[2]   lvttl_cio_d8s2   355.1m   3.646nH   0.863pF
C16   HEX0[3]   lvttl_cio_d8s2   414.4m   3.789nH   0.966pF
C17   HEX0[6]   lvttl_cio_d8s2   556.7m   4.473nH   0.983pF
C18   HEX1[0]   lvttl_cio_d8s2   528.4m   4.394nH   1.094pF
C19   HEX3[3]   lvttl_cio_d8s2   763.6m   6.298nH   1.380pF
C20   HEX3[4]   lvttl_rio_d8s2   749.1m   7.394nH   1.433pF
C22   HEX2[5]   lvttl_rio_d8s2   870.5m   8.142nH   1.672pF
D11   GND   GND
D12   SW[2]   lvttl_cin_p   352.0m   3.084nH   0.728pF
D13   LEDR[4]   lvttl_cio_d8s2   314.2m   2.794nH   0.627pF
D14   LEDR[7]   lvttl_cio_d8s2   281.2m   2.837nH   0.717pF
D15   HEX0[7]   lvttl_cio_d8s2   274.0m   2.723nH   0.721pF
D16   GND   GND
D17   HEX0[5]   lvttl_cio_d8s2   565.9m   4.962nH   0.996pF
D18   HEX1[1]   lvttl_rio_d8s2   514.2m   4.734nH   1.044pF
D19   HEX3[5]   lvttl_rio_d8s2   708.9m   6.563nH   1.329pF
D20   GND   GND
D22   HEX3[7]   lvttl_rio_d8s2   873.7m   7.558nH   1.558pF
D4   GND   GND
E14   LEDR[6]   lvttl_cio_d8s2   236.6m   2.129nH   0.596pF
E15   HEX0[1]   lvttl_cio_d8s2   324.9m   2.789nH   0.681pF
E16   HEX0[4]   lvttl_cio_d8s2   339.2m   3.035nH   0.711pF
E17   HEX3[6]   lvttl_rio_d8s2   483.8m   4.732nH   1.030pF
E18   HEX1[2]   lvttl_rio_d8s2   498.5m   4.115nH   1.034pF
E19   HEX4[2]   lvttl_rio_d8s2   565.4m   5.750nH   1.221pF
E2   GND   GND
E20   HEX4[1]   lvttl_rio_d8s2   632.0m   6.551nH   1.226pF
E21   HEX3[2]   lvttl_rio_d8s2   778.5m   6.938nH   1.410pF
E22   HEX3[1]   lvttl_rio_d8s2   802.9m   7.537nH   1.491pF
E7   GND   GND
F10   GND   GND
F11   VCCIO8   POWER
F12   VCCIO7   POWER
F13   GND   GND
F14   VCCIO7   POWER
F15   SW[9]   lvttl_cin_p   264.6m   2.631nH   0.845pF
F16   ARDUINO_RESET_N   33schmitttrig_cio_d8s2_p   257.4m   2.612nH   0.822pF
F17   HEX4[7]   lvttl_rio_d8s2   466.8m   4.718nH   1.000pF
F18   HEX4[0]   lvttl_rio_d8s2   511.9m   5.442nH   1.043pF
F19   HEX4[5]   lvttl_rio_d8s2   607.3m   5.799nH   1.111pF
F20   HEX4[6]   lvttl_rio_d8s2   650.1m   5.945nH   1.357pF
F21   HEX3[0]   lvttl_rio_d8s2   680.2m   6.239nH   1.405pF
F22   DRAM_DQ[15]   lvttl_rio_d8s2_p   776.2m   7.240nH   1.440pF
F9   VCCIO8   POWER
G10   VCCIO8   POWER
G11   VCCIO8   POWER
G12   VCCIO7   POWER
G13   VCCIO7   POWER
G14   VCCIO7   POWER
G15   GND   GND
G16   VCCD_PLL2   POWER
G18   GND   GND
G19   DRAM_DQ[14]   lvttl_rio_d8s2_p   732.0m   7.276nH   1.501pF
G20   DRAM_DQ[13]   lvttl_rio_d8s2_p   710.4m   7.236nH   1.501pF
G21   GND   GND
G22   DRAM_DQ[12]   lvttl_rio_d8s2_p   765.1m   6.251nH   1.404pF
G6   GND   GND
G7   VCCD_PLL3   POWER
G8   GND   GND
H15   VCCA2   POWER
H16   VCCIO6   POWER
H19   HEX4[4]   lvttl_rio_d8s2   261.8m   2.683nH   0.704pF
H21   DRAM_DQ[10]   lvttl_rio_d8s2_p   695.6m   6.365nH   1.287pF
H22   DRAM_DQ[11]   lvttl_rio_d8s2_p   659.0m   6.858nH   1.213pF
H7   VCCA_ADC   POWER
H8   VCCA3   POWER
J16   GND   GND
J17   VCCIO6   POWER
J18   HEX4[3]   lvttl_rio_d8s2   189.6m   2.001nH   0.545pF
J19   GND   GND
J2   GND   GND
J20   HEX5[0]   lvttl_rio_d8s2   423.1m   3.410nH   0.853pF
J21   DRAM_UDQM   lvttl_rio_d8s2   653.7m   6.752nH   1.335pF
J22   DRAM_DQ[9]   lvttl_rio_d8s2_p   705.3m   5.913nH   1.403pF
J6   GND   GND
J7   VCCINT   POWER
K10   GND   GND
K11   VCC   POWER
K12   GND   GND
K13   VCC   POWER
K16   VCCIO6   POWER
K17   VCCIO6   POWER
K20   HEX5[1]   lvttl_rio_d8s2   392.4m   3.688nH   0.802pF
K3   GND   GND
K7   VCCIO1A   POWER
L10   VCC   POWER
L11   VCC   POWER
L12   VCC   POWER
L13   GND   GND
L14   DRAM_CLK   lvttl_rio_d8s2   189.1m   1.827nH   0.664pF
L16   VCCIO6   POWER
L17   GND   GND
L18   HEX5[2]   lvttl_rio_d8s2   290.6m   2.908nH   0.757pF
L19   HEX5[7]   lvttl_rio_d8s2   459.9m   3.942nH   0.878pF
L21   GND   GND
L5   GND   GND
L6   VCCIO1A   POWER
L7   VCCIO1B   POWER
M10   GND   GND
M11   VCC   POWER
M12   VCC   POWER
M13   VCC   POWER
M16   GND   GND
M17   VCCIO6   POWER
M19   GND   GND
M20   HEX5[4]   lvttl_rio_d8s2   432.9m   4.020nH   0.848pF
M6   VCCIO1B   POWER
M7   GND   GND
N1   VGA_VS   lvttl_rio_d8s2   562.3m   5.772nH   1.046pF
N10   VCC   POWER
N11   GND   GND
N12   VCC   POWER
N13   GND   GND
N14   MAX10_CLK2_50   lvttl_rin_p   222.0m   2.461nH   0.722pF
N16   VCCIO5   POWER
N17   VCCIO6   POWER
N18   HEX5[3]   lvttl_rio_d8s2   322.0m   3.439nH   0.764pF
N19   HEX5[5]   lvttl_rio_d8s2   329.7m   3.736nH   0.832pF
N2   VGA_B[3]   lvttl_rio_d8s2   491.2m   4.983nH   0.903pF
N20   HEX5[6]   lvttl_rio_d8s2   469.3m   4.833nH   0.955pF
N22   DRAM_CKE   lvttl_rio_d8s2   538.2m   4.767nH   0.960pF
N3   VGA_HS   lvttl_rio_d8s2   442.6m   4.334nH   0.802pF
N5   ADC_CLK_10   lvttl_rin_p   218.0m   2.241nH   0.600pF
N6   VCCIO2   POWER
N7   VCCIO2   POWER
P1   VGA_B[0]   lvttl_rio_d8s2   548.9m   4.871nH   1.019pF
P11   MAX10_CLK1_50   lvttl_cin_p   176.5m   1.812nH   0.651pF
P16   VCCIO5   POWER
P17   GND   GND
P18   DRAM_ADDR[8]   lvttl_rio_d8s2   248.5m   2.659nH   0.671pF
P19   DRAM_ADDR[9]   lvttl_rio_d8s2   384.1m   3.465nH   0.812pF
P2   GND   GND
P20   DRAM_ADDR[11]   lvttl_rio_d8s2   401.8m   3.793nH   0.848pF
P21   DRAM_DQ[8]   lvttl_rio_d8s2_p   484.5m   4.771nH   0.891pF
P4   VGA_B[2]   lvttl_rio_d8s2   435.8m   4.115nH   0.958pF
P6   GND   GND
P7   VCCIO2   POWER
R1   VGA_G[3]   lvttl_rio_d8s2   564.3m   5.023nH   1.113pF
R16   VCCIO5   POWER
R17   VCCIO5   POWER
R18   DRAM_ADDR[7]   lvttl_rio_d8s2   301.0m   2.886nH   0.780pF
R19   GND   GND
R2   VGA_G[2]   lvttl_rio_d8s2   477.4m   5.188nH   0.897pF
R20   DRAM_ADDR[12]   lvttl_rio_d8s2   457.8m   4.489nH   0.975pF
R21   GND   GND
R6   VCCIO2   POWER
R8   VCCA1   POWER
T1   VGA_B[1]   lvttl_rio_d8s2   575.3m   5.438nH   1.235pF
T10   VCCIO3   POWER
T11   VCCIO3   POWER
T12   VCCIO4   POWER
T13   VCCIO4   POWER
T14   GND   GND
T15   VCCA4   POWER
T16   GND   GND
T17   VCCIO5   POWER
T18   DRAM_ADDR[5]   lvttl_rio_d8s2   392.4m   3.467nH   0.959pF
T19   DRAM_ADDR[6]   lvttl_rio_d8s2   442.3m   3.712nH   1.090pF
T2   VGA_G[1]   lvttl_rio_d8s2   560.7m   4.572nH   1.186pF
T20   DRAM_ADDR[10]   lvttl_rio_d8s2   500.7m   4.206nH   1.044pF
T21   DRAM_BA[0]   lvttl_rio_d8s2   548.0m   5.719nH   1.004pF
T22   DRAM_BA[1]   lvttl_rio_d8s2   564.4m   5.831nH   1.030pF
T4   GND   GND
T7   VCCD_PLL1   POWER
T8   GND   GND
T9   VCCIO3   POWER
U10   GND   GND
U11   VCCIO4   POWER
U12   VCCIO4   POWER
U13   GND   GND
U14   VCCIO4   POWER
U16   VCCD_PLL4   POWER
U17   DRAM_ADDR[0]   lvttl_rio_d8s2   264.6m   2.622nH   0.820pF
U18   DRAM_ADDR[3]   lvttl_rio_d8s2   274.6m   2.776nH   0.824pF
U19   DRAM_ADDR[4]   lvttl_rio_d8s2   429.0m   3.743nH   1.135pF
U20   DRAM_CS_N   lvttl_rio_d8s2   494.5m   4.660nH   1.030pF
U21   DRAM_CAS_N   lvttl_rio_d8s2   622.4m   6.049nH   1.325pF
U22   DRAM_RAS_N   lvttl_rio_d8s2   637.7m   5.812nH   1.303pF
U8   VCCIO3   POWER
U9   VCCIO3   POWER
V1   VGA_R[1]   lvttl_rio_d8s2   718.1m   6.793nH   1.308pF
V11   GSENSOR_SDI   lvttl_cio_d8s2_p   192.9m   1.931nH   0.550pF
V12   GSENSOR_SDO   lvttl_cio_d8s2_p   233.8m   2.250nH   0.660pF
V18   DRAM_ADDR[2]   lvttl_rio_d8s2   421.9m   3.916nH   1.122pF
V19   GND   GND
V2   GND   GND
V20   DRAM_WE_N   lvttl_rio_d8s2   542.9m   5.168nH   1.152pF
V21   DRAM_DQ[7]   lvttl_rio_d8s2_p   698.3m   5.814nH   1.264pF
V22   DRAM_LDQM   lvttl_rio_d8s2   693.7m   6.747nH   1.294pF
V6   GND   GND
W1   VGA_G[0]   lvttl_rio_d8s2   689.1m   5.514nH   1.359pF
W19   DRAM_ADDR[1]   lvttl_rio_d8s2   539.7m   4.615nH   1.234pF
W20   DRAM_DQ[6]   lvttl_rio_d8s2_p   559.4m   5.197nH   1.281pF
W21   GND   GND
W22   DRAM_DQ[5]   lvttl_rio_d8s2_p   759.0m   6.620nH   1.388pF
Y1   VGA_R[3]   lvttl_cio_d8s2   863.3m   7.327nH   1.574pF
Y10   ARDUINO_IO[5]   lvttl_cio_d8s2_p   432.7m   4.262nH   0.901pF
Y12   GND   GND
Y13   GSENSOR_INT[2]   lvttl_cin_p   397.8m   3.733nH   0.865pF
Y14   GSENSOR_INT[1]   lvttl_cin_p   408.5m   3.852nH   0.888pF
Y15   GND   GND
Y19   ARDUINO_IO[12]   lvttl_cio_d8s2_p   619.3m   5.133nH   1.296pF
Y2   VGA_R[2]   lvttl_cio_d8s2   818.0m   7.853nH   1.582pF
Y20   DRAM_DQ[1]   lvttl_rio_d8s2_p   708.7m   5.798nH   1.454pF
Y21   DRAM_DQ[0]   lvttl_rio_d8s2_p   692.6m   6.308nH   1.466pF
Y22   DRAM_DQ[4]   lvttl_rio_d8s2_p   748.5m   7.167nH   1.366pF
Y9   GND   GND
| Models and submodels in the file (8): 33schmitttrig_cin_p (Input), 33schmitttrig_cio_d8s2_p (I/O), lvttl_cin_p (Input), lvttl_cio_d8s2 (I/O), lvttl_cio_d8s2_p (I/O), lvttl_rin_p (Input), lvttl_rio_d8s2 (I/O), lvttl_rio_d8s2_p (I/O)
